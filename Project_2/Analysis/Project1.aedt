# Ansys Electronics Desktop project, version 2018.2
materials:
  vacuum: permittivity=1
  copper: permeability=0.999991 conductivity=58000000
  iron: permeability=4000 conductivity=10300000
  NdFe30: CoordinateSystemType=Cylindrical permittivity=1 permeability=1.044573 conductivity=625000 magnetic_coercivity{Magnitude=-838000A_per_meter DirComp1=1 DirComp2=0 DirComp3=0} lande_g_factor=2
  NdFe31: CoordinateSystemType=Cylindrical permittivity=1 permeability=1.044573 conductivity=625000 magnetic_coercivity{Magnitude=-838000A_per_meter DirComp1=-1 DirComp2=0 DirComp3=0} lande_g_factor=2

design 20poles24slots (Maxwell 2D, Transient, XY geometry, model units mm)
options: ModelDepth=1meter Multiplier=1
geometry:
  Stator [iron] = user_primitive(RMxprt/SlotCore.dll, DiaGap=161.9mm, DiaYoke=269.24mm, Length=0mm, Skew=0deg, Slots=24, SlotType=2, Hs0=1.03mm, Hs01=0mm, Hs1=0mm, Hs2=29.5mm, Bs0=1.93mm, Bs1=5mm, Bs2=8mm, Rs=5mm, FilletType=0, HalfSlot=0, SegAngle=0deg, LenRegion=200mm, InfoCore=0)
  rotor [iron] = user_primitive(RMxprt/PMCore.dll, DiaGap=160.4mm, DiaYoke=50mm, Length=0mm, Poles=20, PoleType=3, Embrace=0.7, ThickMag=8mm, WidthMag=45mm, Offset=0mm, Bridge=2mm, Rib=3mm, LenRegion=200mm, InfoCore=0)
  magnet [NdFe30] = user_primitive(RMxprt/PMCore.dll, DiaGap=160.4mm, DiaYoke=50mm, Length=0mm, Poles=20, PoleType=3, Embrace=0.7, ThickMag=8mm, WidthMag=45mm, Offset=0mm, Bridge=2mm, Rib=3mm, LenRegion=200mm, InfoCore=1)
  Region [vacuum] = circle(normal=Z, centre=(0mm, 0mm, 0mm), radius=184.39089mm)
  magnet_Separate1..magnet_Separate9 [NdFe30], magnet_Separate10..magnet_Separate19 [NdFe31] = magnet.separate_bodies()
  Band [vacuum] = circle(normal=Z, centre=(0mm, 0mm, 0mm), radius=80.698761mm)
  Circle1 = circle(normal=Z, centre=(0mm, 0mm, 0mm), radius=80.612902mm, uncovered)
  1 [copper] = rectangle(corner=(-1.5mm, 111.5mm, 0mm), x_size=3mm, y_size=-27.5mm)
  1.rotate(axis=Z, angle=-7.5deg)
  2..24 [copper] = 1.duplicate_around_axis(axis=Z, angle=-15deg, total=24)
motion:
  MotionSetup1: Band Move_Type=Rotate Coordinate_System=Global Axis=Z Is_Positive=true InitPos=0deg Angular_Velocity=1000rpm Objects=Band
  Moving1: Moving Objects=[rotor, magnet, magnet_Separate1..magnet_Separate19, Circle1]
boundaries and excitations:
  Zero_Flux: Vector Potential Edges=Region.edge(1 of 1) Value=0
  1: Coil Objects=1 Conductor_number=3 Winding=PhaseA PolarityType=Positive
  2: Coil Objects=2 Conductor_number=3 Winding=PhaseA PolarityType=Negative
  3: Coil Objects=3 Conductor_number=3 Winding=PhaseB PolarityType=Negative
  4: Coil Objects=4 Conductor_number=3 Winding=PhaseB PolarityType=Positive
  5: Coil Objects=5 Conductor_number=3 Winding=PhaseC PolarityType=Positive
  6: Coil Objects=6 Conductor_number=3 Winding=PhaseC PolarityType=Negative
  7: Coil Objects=7 Conductor_number=3 Winding=PhaseA PolarityType=Negative
  8: Coil Objects=8 Conductor_number=3 Winding=PhaseA PolarityType=Positive
  9: Coil Objects=9 Conductor_number=3 Winding=PhaseB PolarityType=Positive
  10: Coil Objects=10 Conductor_number=3 Winding=PhaseB PolarityType=Negative
  11: Coil Objects=11 Conductor_number=3 Winding=PhaseC PolarityType=Negative
  12: Coil Objects=12 Conductor_number=3 Winding=PhaseC PolarityType=Positive
  13: Coil Objects=13 Conductor_number=3 Winding=PhaseA PolarityType=Positive
  14: Coil Objects=14 Conductor_number=3 Winding=PhaseA PolarityType=Negative
  15: Coil Objects=15 Conductor_number=3 Winding=PhaseB PolarityType=Negative
  16: Coil Objects=16 Conductor_number=3 Winding=PhaseB PolarityType=Positive
  17: Coil Objects=17 Conductor_number=3 Winding=PhaseC PolarityType=Positive
  18: Coil Objects=18 Conductor_number=3 Winding=PhaseC PolarityType=Negative
  19: Coil Objects=19 Conductor_number=3 Winding=PhaseA PolarityType=Negative
  20: Coil Objects=20 Conductor_number=3 Winding=PhaseA PolarityType=Positive
  21: Coil Objects=21 Conductor_number=3 Winding=PhaseB PolarityType=Positive
  22: Coil Objects=22 Conductor_number=3 Winding=PhaseB PolarityType=Negative
  23: Coil Objects=23 Conductor_number=3 Winding=PhaseC PolarityType=Negative
  24: Coil Objects=24 Conductor_number=3 Winding=PhaseC PolarityType=Positive
  PhaseA: Winding Group Type=Current IsSolid=false Current=0mA ParallelBranchesNum=1
  PhaseB: Winding Group Type=Current IsSolid=false Current=0mA ParallelBranchesNum=1
  PhaseC: Winding Group Type=Current IsSolid=false Current=0mA ParallelBranchesNum=1
mesh:
  Length2: LengthBased RefineInside Objects=[magnet, magnet_Separate1..magnet_Separate19] MaxLength=3.8189979mm
  Length3: LengthBased RefineInside Objects=rotor MaxLength=5mm
  Length4: LengthBased RefineInside Objects=Stator MaxLength=5mm
  Length5: LengthBased RefineInside Objects=[1..24] MaxLength=5.5312625mm
  initial mesh: MeshMethod=AnsoftTAU
setups:
  Setup1: Transient NonlinearSolverResidual=0.0001 StopTime=0.06s TimeStep=5e-05s SweepSetupType=LinearStep StartValue=0ns StopValue=0.06s StepSize=0.06s InitialTimeStep=0.002s MinTimeStep=0.001s MaxTimeStep=0.003s TimeStepErrTolerance=0.0001
reports:
  Winding Plot 1: InducedVoltage(PhaseA), InducedVoltage(PhaseB), InducedVoltage(PhaseC) vs Time on Setup1 : Transient
  Calculator Expressions Plot 1: Mag_B vs Distance on Setup1 : Transient [Time=all]
  Torque Plot 1: Moving1.Torque vs Time on Setup1 : Transient
  Winding Plot 2: FluxLinkage(PhaseA), FluxLinkage(PhaseB), FluxLinkage(PhaseC) vs Time on Setup1 : Transient
   Plot 1: InducedVoltage(PhaseA)-InducedVoltage(PhaseB), InducedVoltage(PhaseB)-InducedVoltage(PhaseC), InducedVoltage(PhaseC)-InducedVoltage(PhaseA) vs Time on Setup1 : Transient

design 20poles24slots1_Static (Maxwell 2D, Magnetostatic, XY geometry, model units mm)
geometry:
  Stator [iron] = user_primitive(RMxprt/SlotCore.dll, DiaGap=161.9mm, DiaYoke=269.24mm, Length=0mm, Skew=0deg, Slots=24, SlotType=2, Hs0=1.03mm, Hs01=0mm, Hs1=0mm, Hs2=29.5mm, Bs0=1.93mm, Bs1=5mm, Bs2=8mm, Rs=5mm, FilletType=0, HalfSlot=0, SegAngle=0deg, LenRegion=200mm, InfoCore=0)
  rotor [iron] = user_primitive(RMxprt/PMCore.dll, DiaGap=160.4mm, DiaYoke=50mm, Length=0mm, Poles=20, PoleType=3, Embrace=0.7, ThickMag=8mm, WidthMag=45mm, Offset=0mm, Bridge=2mm, Rib=3mm, LenRegion=200mm, InfoCore=0)
  magnet [NdFe30] = user_primitive(RMxprt/PMCore.dll, DiaGap=160.4mm, DiaYoke=50mm, Length=0mm, Poles=20, PoleType=3, Embrace=0.7, ThickMag=8mm, WidthMag=45mm, Offset=0mm, Bridge=2mm, Rib=3mm, LenRegion=200mm, InfoCore=1)
  PhaseA [copper, non-model] = user_primitive(RMxprt/LapCoil.dll, DiaGap=161.9mm, DiaYoke=269.24mm, Length=0mm, Skew=0deg, Slots=20, SlotType=2, Hs0=1.28mm, Hs1=0.1mm, Hs2=29.7mm, Bs0=2.11mm, Bs1=3.14mm, Bs2=5.65mm, Rs=2.5mm, FilletType=0, Layers=1, CoilPitch=5, EndExt=6mm, SpanExt=18mm, BendAngle=0deg, SegAngle=10deg, LenRegion=200mm, InfoCoil=1)
  PhaseA.rotate(axis=Z, angle=10deg)
  PhaseA.rotate(axis=Z, angle=-20deg)
  PhaseA.rotate(axis=Z, angle=-5deg)
  PhaseA.rotate(axis=Z, angle=-2deg)
  PhaseA.rotate(axis=Z, angle=0.5deg)
  PhaseA2 [copper, non-model] = PhaseA.duplicate_around_axis(axis=Z, angle=-15deg, total=2)
  PhaseB [copper, non-model] = PhaseA2.duplicate_around_axis(axis=Z, angle=-15deg, total=2)
  PhaseB2, PhaseC, PhaseC2 [copper, non-model] = PhaseB.duplicate_around_axis(axis=Z, angle=-15deg, total=4)
  PhaseA3 [copper, non-model] = PhaseC2.duplicate_around_axis(axis=Z, angle=-105deg, total=2)
  PhaseA4, PhaseB3, PhaseB4, PhaseC3, PhaseC4 [copper, non-model] = PhaseA3.duplicate_around_axis(axis=Z, angle=-15deg, total=6)
  Region [vacuum] = circle(normal=Z, centre=(0mm, 0mm, 0mm), radius=184.39089mm)
  magnet_Separate1..magnet_Separate9 [NdFe30], magnet_Separate10..magnet_Separate19 [NdFe31] = magnet.separate_bodies()
  Circle1 [vacuum, non-model] = circle(normal=Z, centre=(0mm, 0mm, 0mm), radius=80.5367mm)
boundaries and excitations:
  Zero_Flux: Vector Potential Edges=Region.edge(1 of 1) Value=0
parameters:
  Torque1: Torque Coordinate_System=Global Is_Positive=true Objects=[magnet, magnet_Separate1..magnet_Separate12, magnet_Separate14, magnet_Separate13, magnet_Separate15..magnet_Separate19, rotor]
mesh:
  Rotor: LengthBased RefineInside Objects=rotor MaxLength=5mm
  Magnet: LengthBased RefineInside Objects=[magnet, magnet_Separate1..magnet_Separate14, magnet_Separate16, magnet_Separate15, magnet_Separate17, magnet_Separate18, magnet_Separate19] MaxLength=2mm
  SA_Stator: SurfApproxBased Objects=Stator CurvedSurfaceApproxChoice=ManualSettings NormalDev=3deg AspectRatio=5
  initial mesh: MeshMethod=AnsoftTAU
setups:
  Setup1: Magnetostatic MaximumPasses=10 MinimumPasses=2 MinimumConvergedPasses=1 PercentRefinement=15 PercentError=0.1 NonLinearResidual=1e-06
field plots:
  Flux_Lines1: A on Setup1 : LastAdaptive
