# Ansys Electronics Desktop project, version 2018.2
materials:
  vacuum: permittivity=1
  copper: permeability=0.999991 conductivity=58000000
  iron: permeability=4000 conductivity=10300000
  NdFe30: CoordinateSystemType=Cylindrical permittivity=1 permeability=1.044573 conductivity=625000 magnetic_coercivity{Magnitude=-838000A_per_meter DirComp1=1 DirComp2=0 DirComp3=0} lande_g_factor=2
  NdFe31: CoordinateSystemType=Cylindrical permittivity=1 permeability=1.044573 conductivity=625000 magnetic_coercivity{Magnitude=-838000A_per_meter DirComp1=-1 DirComp2=0 DirComp3=0} lande_g_factor=2

design 20poles24slots (Maxwell 2D, Transient, XY geometry, model units mm)
options: ModelDepth=1meter Multiplier=1
geometry:
  Stator [iron] = user_primitive(RMxprt/SlotCore.dll, DiaGap=161.9mm, DiaYoke=269.24mm, Length=0mm, Skew=0deg, Slots=24, SlotType=2, Hs0=1.03mm, Hs01=0mm, Hs1=0mm, Hs2=29.5mm, Bs0=1.93mm, Bs1=5mm, Bs2=8mm, Rs=5mm, FilletType=0, HalfSlot=0, SegAngle=0deg, LenRegion=200mm, InfoCore=0)
  rotor [iron] = user_primitive(RMxprt/PMCore.dll, DiaGap=160.4mm, DiaYoke=50mm, Length=0mm, Poles=20, PoleType=3, Embrace=0.7, ThickMag=8mm, WidthMag=45mm, Offset=0mm, Bridge=2mm, Rib=3mm, LenRegion=200mm, InfoCore=0)
  magnet [NdFe30] = user_primitive(RMxprt/PMCore.dll, DiaGap=160.4mm, DiaYoke=50mm, Length=0mm, Poles=20, PoleType=3, Embrace=0.7, ThickMag=8mm, WidthMag=45mm, Offset=0mm, Bridge=2mm, Rib=3mm, LenRegion=200mm, InfoCore=1)
  PhaseA [copper] = user_primitive(RMxprt/LapCoil.dll, DiaGap=161.9mm, DiaYoke=269.24mm, Length=0mm, Skew=0deg, Slots=20, SlotType=2, Hs0=1.28mm, Hs1=0.1mm, Hs2=29.7mm, Bs0=2.11mm, Bs1=3.14mm, Bs2=5.65mm, Rs=2.5mm, FilletType=0, Layers=1, CoilPitch=5, EndExt=6mm, SpanExt=18mm, BendAngle=0deg, SegAngle=10deg, LenRegion=200mm, InfoCoil=1)
  PhaseA.rotate(axis=Z, angle=10deg)
  PhaseA.rotate(axis=Z, angle=-20deg)
  PhaseA.rotate(axis=Z, angle=-5deg)
  PhaseA.rotate(axis=Z, angle=-2deg)
  PhaseA.rotate(axis=Z, angle=0.5deg)
  PhaseA2 [copper] = PhaseA.duplicate_around_axis(axis=Z, angle=-15deg, total=2)
  PhaseB [copper] = PhaseA2.duplicate_around_axis(axis=Z, angle=-15deg, total=2)
  PhaseB2, PhaseC, PhaseC2 [copper] = PhaseB.duplicate_around_axis(axis=Z, angle=-15deg, total=4)
  PhaseA3 [copper] = PhaseC2.duplicate_around_axis(axis=Z, angle=-105deg, total=2)
  PhaseA4, PhaseB3, PhaseB4, PhaseC3, PhaseC4 [copper] = PhaseA3.duplicate_around_axis(axis=Z, angle=-15deg, total=6)
  Region [vacuum] = circle(normal=Z, centre=(0mm, 0mm, 0mm), radius=184.39089mm)
  magnet_Separate1..magnet_Separate9 [NdFe30], magnet_Separate10..magnet_Separate19 [NdFe31] = magnet.separate_bodies()
boundaries and excitations:
  Zero_Flux: Vector Potential Edges=Region.edge(1 of 1) Value=0
mesh:
  initial mesh: MeshMethod=AnsoftTAU

design 20poles24slots1_Static (Maxwell 2D, Magnetostatic, XY geometry, model units mm)
geometry:
  Stator [iron] = user_primitive(RMxprt/SlotCore.dll, DiaGap=161.9mm, DiaYoke=269.24mm, Length=0mm, Skew=0deg, Slots=24, SlotType=2, Hs0=1.03mm, Hs01=0mm, Hs1=0mm, Hs2=29.5mm, Bs0=1.93mm, Bs1=5mm, Bs2=8mm, Rs=5mm, FilletType=0, HalfSlot=0, SegAngle=0deg, LenRegion=200mm, InfoCore=0)
  rotor [iron] = user_primitive(RMxprt/PMCore.dll, DiaGap=160.4mm, DiaYoke=50mm, Length=0mm, Poles=20, PoleType=3, Embrace=0.7, ThickMag=8mm, WidthMag=45mm, Offset=0mm, Bridge=2mm, Rib=3mm, LenRegion=200mm, InfoCore=0)
  magnet [NdFe30] = user_primitive(RMxprt/PMCore.dll, DiaGap=160.4mm, DiaYoke=50mm, Length=0mm, Poles=20, PoleType=3, Embrace=0.7, ThickMag=8mm, WidthMag=45mm, Offset=0mm, Bridge=2mm, Rib=3mm, LenRegion=200mm, InfoCore=1)
  PhaseA [copper, non-model] = user_primitive(RMxprt/LapCoil.dll, DiaGap=161.9mm, DiaYoke=269.24mm, Length=0mm, Skew=0deg, Slots=20, SlotType=2, Hs0=1.28mm, Hs1=0.1mm, Hs2=29.7mm, Bs0=2.11mm, Bs1=3.14mm, Bs2=5.65mm, Rs=2.5mm, FilletType=0, Layers=1, CoilPitch=5, EndExt=6mm, SpanExt=18mm, BendAngle=0deg, SegAngle=10deg, LenRegion=200mm, InfoCoil=1)
  PhaseA.rotate(axis=Z, angle=10deg)
  PhaseA.rotate(axis=Z, angle=-20deg)
  PhaseA.rotate(axis=Z, angle=-5deg)
  PhaseA.rotate(axis=Z, angle=-2deg)
  PhaseA.rotate(axis=Z, angle=0.5deg)
  PhaseA2 [copper, non-model] = PhaseA.duplicate_around_axis(axis=Z, angle=-15deg, total=2)
  PhaseB [copper, non-model] = PhaseA2.duplicate_around_axis(axis=Z, angle=-15deg, total=2)
  PhaseB2, PhaseC, PhaseC2 [copper, non-model] = PhaseB.duplicate_around_axis(axis=Z, angle=-15deg, total=4)
  PhaseA3 [copper, non-model] = PhaseC2.duplicate_around_axis(axis=Z, angle=-105deg, total=2)
  PhaseA4, PhaseB3, PhaseB4, PhaseC3, PhaseC4 [copper, non-model] = PhaseA3.duplicate_around_axis(axis=Z, angle=-15deg, total=6)
  Region [vacuum] = circle(normal=Z, centre=(0mm, 0mm, 0mm), radius=184.39089mm)
  magnet_Separate1..magnet_Separate9 [NdFe30], magnet_Separate10..magnet_Separate19 [NdFe31] = magnet.separate_bodies()
  Circle1 [vacuum, non-model] = circle(normal=Z, centre=(0mm, 0mm, 0mm), radius=80.5367mm)
boundaries and excitations:
  Zero_Flux: Vector Potential Edges=Region.edge(1 of 1) Value=0
parameters:
  Torque1: Torque Coordinate_System=Global Is_Positive=true Objects=[magnet, magnet_Separate1..magnet_Separate12, magnet_Separate14, magnet_Separate13, magnet_Separate15..magnet_Separate19, rotor]
mesh:
  Rotor: LengthBased RefineInside Objects=rotor MaxLength=5mm
  Magnet: LengthBased RefineInside Objects=[magnet, magnet_Separate1..magnet_Separate14, magnet_Separate16, magnet_Separate15, magnet_Separate17, magnet_Separate18, magnet_Separate19] MaxLength=2mm
  SA_Stator: SurfApproxBased Objects=Stator CurvedSurfaceApproxChoice=ManualSettings NormalDev=3deg AspectRatio=5
  initial mesh: MeshMethod=AnsoftTAU
setups:
  Setup1: Magnetostatic MaximumPasses=10 MinimumPasses=2 MinimumConvergedPasses=1 PercentRefinement=15 PercentError=0.1 NonLinearResidual=1e-06
field plots:
  B_Vector1: B on Setup1 : LastAdaptive
