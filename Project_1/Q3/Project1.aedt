# Ansys Electronics Desktop project, version 2018.2
materials:
  vacuum: permittivity=1
  copper: permeability=0.999991 conductivity=58000000
  iron: permeability=4000 conductivity=10300000
  M19_29G: permeability{BType=normal HUnit=A_per_meter BUnit=tesla curve (0, 0) (22.28, 0.05) (25.46, 0.1) (31.83, 0.15) (47.74, 0.36) (63.66, 0.54) (79.57, 0.65) (159.15, 0.99) (318.3, 1.2) (477.46, 1.28) (636.61, 1.33) (795.77, 1.36) (1591.5, 1.44) (3183, 1.52) (4774.6, 1.58) (6366.1, 1.63) (7957.7, 1.67) (15915, 1.8) (31830, 1.9) (111407, 2) (190984, 2.1) (350138, 2.3) (509292, 2.5)} conductivity=1960000 core_loss_type="Electrical Steel" core_loss_kh=164.2 core_loss_kc=0.409 mass_density=7650

design Maxwell2DDesign1 (Maxwell 2D, Magnetostatic, XY geometry, model units mm)
geometry:
  Rectangle1 [M19_29G] = rectangle(corner=(-30mm, 35mm, 0mm), x_size=60mm, y_size=-70mm)
  Rectangle2 = rectangle(corner=(-15mm, 20mm, 0mm), x_size=30mm, y_size=-40mm)
  Rectangle1.subtract(Rectangle2)
  Circle1 = circle(normal=Z, centre=(22.5mm, 0mm, 0mm), radius=12.5mm)
  Rectangle1.subtract(Circle1)
  Circle2 [M19_29G] = circle(normal=Z, centre=(22.5mm, 0mm, 0mm), radius=12mm)
  Circle3 = circle(normal=Z, centre=(22.5mm, 0mm, 0mm), radius=10mm)
  Rectangle3 = rectangle(corner=(15mm, 10mm, 0mm), x_size=-7mm, y_size=-20mm)
  Circle2.subtract(Rectangle3)
  Rectangle4 = rectangle(corner=(30mm, 10mm, 0mm), x_size=6mm, y_size=-20mm)
  Circle2.subtract(Rectangle4)
  Circle2.unite(Circle3)
  coordinate_system ObjectCS1 = object of Circle2: Origin=Circle2.edge(#178) xAxis{xDirection=1 yDirection=0 zDirection=0} yAxis{xDirection=0 yDirection=1 zDirection=0}
  Rectangle5 [copper] = rectangle(corner=(-15mm, 15mm, 0mm), x_size=10mm, y_size=-30mm)
  Rectangle6 [copper] = rectangle(corner=(-30mm, 15mm, 0mm), x_size=-10mm, y_size=-30mm)
  Circle4 [vacuum] = circle(normal=Z, centre=(0mm, 0mm, 0mm), radius=72.111026mm)
  Circle2.rotate(axis=Z, angle=-45deg) in ObjectCS1
  Circle2.rotate(axis=Z, angle=-45deg) in ObjectCS1
  Circle2.rotate(axis=Z, angle=90deg) in ObjectCS1
  Circle2.rotate(axis=Z, angle=-45deg) in ObjectCS1
  Circle2.rotate(axis=Z, angle=-45deg) in ObjectCS1
  Circle2.rotate(axis=Z, angle=90deg) in ObjectCS1
  Circle2.rotate(axis=Z, angle=-45deg) in ObjectCS1
  Circle2.rotate(axis=Z, angle=-45deg) in ObjectCS1
boundaries and excitations:
  VectorPotential1: Vector Potential Edges=Circle4.edge(1 of 1) Value=0
  Current1: Current Objects=Rectangle5 Current=750A IsPositive=false
  Current2: Current Objects=Rectangle6 Current=750A IsPositive=true
parameters:
  Matrix1: Matrix Current1: NumberOfTurns=250 ReturnPath=Current2
mesh:
  initial mesh: MeshMethod=AnsoftTAU
setups:
  Setup1: Magnetostatic MaximumPasses=10 MinimumPasses=2 MinimumConvergedPasses=1 PercentRefinement=30 PercentError=0.1 NonLinearResidual=1e-07
field calculator expressions:
  total_en = energy | EnterVolume(AllObjects) | VolumeValue | Integrate
field plots:
  B_Vector1: B over Rectangle1, Circle2, Rectangle5, Rectangle6, Circle4 on Setup1 : LastAdaptive
reports:
  Calculator Expressions Plot 1: total_en vs X on Setup1 : LastAdaptive

design Maxwell2DDesign2 (Maxwell 2D, Transient, XY geometry, model units mm)
options: ComputeTransientInductance ModelDepth=20mm Multiplier=1
geometry:
  Rectangle1 [M19_29G] = rectangle(corner=(-30mm, 35mm, 0mm), x_size=60mm, y_size=-70mm)
  Rectangle2 = rectangle(corner=(-15mm, 20mm, 0mm), x_size=30mm, y_size=-40mm)
  Rectangle1.subtract(Rectangle2)
  Circle1 = circle(normal=Z, centre=(22.5mm, 0mm, 0mm), radius=12.5mm)
  Rectangle1.subtract(Circle1)
  Circle2 [M19_29G] = circle(normal=Z, centre=(22.5mm, 0mm, 0mm), radius=12mm)
  Circle3 = circle(normal=Z, centre=(22.5mm, 0mm, 0mm), radius=10mm)
  Rectangle3 = rectangle(corner=(15mm, 10mm, 0mm), x_size=-7mm, y_size=-20mm)
  Circle2.subtract(Rectangle3)
  Rectangle4 = rectangle(corner=(30mm, 10mm, 0mm), x_size=6mm, y_size=-20mm)
  Circle2.subtract(Rectangle4)
  Circle2.unite(Circle3)
  coordinate_system ObjectCS1 = object of Circle2: Origin=Circle2.edge(#178) xAxis{xDirection=1 yDirection=0 zDirection=0} yAxis{xDirection=0 yDirection=1 zDirection=0}
  Rectangle5 [copper] = rectangle(corner=(-15mm, 15mm, 0mm), x_size=10mm, y_size=-30mm)
  Rectangle6 [copper] = rectangle(corner=(-30mm, 15mm, 0mm), x_size=-10mm, y_size=-30mm)
  Circle4 [vacuum] = circle(normal=Z, centre=(0mm, 0mm, 0mm), radius=72.111026mm)
  Circle2.rotate(axis=Z, angle=-45deg) in ObjectCS1
  Circle2.rotate(axis=Z, angle=-45deg) in ObjectCS1
  Circle2.rotate(axis=Z, angle=90deg) in ObjectCS1
  Band [vacuum] = circle(normal=Z, centre=(0mm, 0mm, 0mm), radius=12.244182mm) in ObjectCS1
motion:
  MotionSetup1: Band Move_Type=Rotate Coordinate_System=ObjectCS1 Axis=Z Is_Positive=true InitPos=-45deg Angular_Velocity=0rpm Moment_of_Inertia=1e-06 Damping=0 Load_Torque=0NewtonMeter Objects=Band
  Moving1: Moving Objects=Circle2
boundaries and excitations:
  VectorPotential1: Vector Potential Edges=Circle4.edge(1 of 1) Value=0
  Rectangle6: Coil Objects=Rectangle6 Conductor_number=250 Winding=Winding1 PolarityType=Positive
  Rectangle5: Coil Objects=Rectangle5 Conductor_number=250 Winding=Winding1 PolarityType=Negative
  Winding1: Winding Group Type=Current IsSolid=false Current=if(mod(time,15ms)>10ms,0A,3A) ParallelBranchesNum=1
parameters:
  Torque1: Torque Coordinate_System=Global Is_Positive=true Objects=Circle2
mesh:
  Length1: LengthBased RefineInside Objects=Band MaxLength=2mm
  initial mesh: MeshMethod=AnsoftTAU
setups:
  Setup1: Transient NonlinearSolverResidual=1e-07 StopTime=0.1s TimeStep=0.0002s InitialTimeStep=0.002s MinTimeStep=0.001s MaxTimeStep=0.003s TimeStepErrTolerance=0.0001
field calculator expressions:
  total_energy = energy | EnterVolume(AllObjects) | VolumeValue | Integrate
field plots:
  energy1: Energy over Rectangle1, Circle2, Rectangle5, Rectangle6, Circle4, Band on Setup1 : Transient at Time=-1
  Mag_B1: B over Rectangle1, Circle2, Rectangle5, Rectangle6, Circle4, Band on Setup1 : Transient at Time=-1
reports:
  Torque Plot 1: Torque1.Torque vs Time on Setup1 : Transient
  Calculator Expressions Plot 1: total_energy vs Time on Setup1 : Transient
  Position Plot 1: Moving1.Position vs Time on Setup1 : Transient
  Winding Plot 2: InputCurrent(Winding1) vs Time on Setup1 : Transient
  Winding Plot 3: InputCurrent(Winding1) vs Time on Setup1 : Transient
  Speed Plot 1: Moving1.Speed vs Time on Setup1 : Transient
